* UTIL-01 ATTENUVERTER - dual attenuverter / offset
* Generated from attenuverter by pcbgen. Do not edit.
*
* Nodes are the design's net names. GND is node 0.
* Parameters this netlist expects a deck to set:
*   norm_J1 = 1m   normalling contact, ohms
*   norm_J2 = 1m   normalling contact, ohms
*   norm_J3 = 1m   normalling contact, ohms
*   norm_J4 = 1m   normalling contact, ohms
*   k_RV1 = 0.5   rotation, 0 to 1
*   k_RV2 = 0.5   rotation, 0 to 1
*
.param norm_J1=1m norm_J2=1m norm_J3=1m norm_J4=1m k_RV1=0.5 k_RV2=0.5
RJ1n IN1 OFFSET {norm_J1}
* J2: tip on OUT1, switch pin unused
RJ3n IN2 OFFSET {norm_J3}
* J4: tip on OUT2, switch pin unused
RRV1hi BUF1 WIPER1 {max(1m,100k*(1-k_RV1))}
RRV1lo WIPER1 0 {max(1m,100k*k_RV1)}
RRV2hi BUF2 WIPER2 {max(1m,100k*(1-k_RV2))}
RRV2lo WIPER2 0 {max(1m,100k*k_RV2)}
XU1_1 IN1 BUF1 P12V N12V U1_o1 OPA2197
VU1_o1 U1_o1 BUF1 DC 0 AC 0
XU1_7 WIPER1 INV1 P12V N12V U1_o7 OPA2197
VU1_o7 U1_o7 OA1 DC 0 AC 0
RR9 IN1 0 1meg
RR1 BUF1 INV1 10k
RR2 INV1 OA1 10k
CC9 INV1 OA1 10p
RR3 OA1 OUT1 1k
CC3 P12V 0 100n
CC4 N12V 0 100n
XU2_1 IN2 BUF2 P12V N12V U2_o1 OPA2197
VU2_o1 U2_o1 BUF2 DC 0 AC 0
XU2_7 WIPER2 INV2 P12V N12V U2_o7 OPA2197
VU2_o7 U2_o7 OA2 DC 0 AC 0
RR10 IN2 0 1meg
RR4 BUF2 INV2 10k
RR5 INV2 OA2 10k
CC10 INV2 OA2 10p
RR6 OA2 OUT2 1k
CC11 P12V 0 100n
CC12 N12V 0 100n
XU3 P12V 0 NR OFFSET REF5050
CC6 P12V 0 1u
CC7 OFFSET 0 1u
CC8 NR 0 1u
* J5: connector, nodes come from the deck
DD2 P12_RAW P12V B5819W
CC1 P12V 0 10u
DD1 N12V N12_RAW B5819W
CC2 N12V 0 10u
