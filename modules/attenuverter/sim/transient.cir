* UTIL-01 channel 1 in time: does it keep up with audio?
*
* The demanding case for a unity-gain stage of this kind is a full-scale
* signal at the top of the band: +/-10 V at 20 kHz needs 2*pi*20k*10 =
* 1.26 V/us of slew. The OPA2197 datasheet says 20 V/us, so there should be
* about sixteen times the margin, and this checks that the margin is really
* there rather than assumed, through two cascaded stages.
*
* Two knob positions. At k = 1 the feedback network cancels out of the
* transfer exactly, so the only frequency dependence is the amplifiers'
* and their input capacitance (see the stability deck).
* At k = 0 the output is -Zf/Ra, and Zf is R_f with the 10 pF compensation
* capacitor across it: with R_f = 10k that is a 1.6 MHz corner, far above
* the band. Both positions are asserted at 0.5 %; the stability deck holds
* the tighter small-signal flatness limit.
*
* No step response here on purpose. Slew rate is a parameter of the model --
* it was built to produce the datasheet's 20 V/us -- so measuring it back
* would confirm the model and say nothing about the circuit. The stability
* deck does the small-signal work.

.include modules/_models/devices.lib
.include modules/attenuverter/sim/attenuverter.cir

Vpos P12_RAW 0 DC 12
Vneg N12_RAW 0 DC -12
.param rp1=1m
* Full-scale 20 kHz sine.
Vsig CABLE1 0 DC 0 SIN(0 10 20k)
Rp1  CABLE1 IN1 {rp1}
* A realistic module on the end of the cable.
Rload OUT1 0 100k

.control
alterparam norm_J1 = 1G
foreach kk 1 0
  alterparam k_RV1 = $kk
  reset
  * The fourth argument starts recording at 60 us, past the first cycle, so
  * the comparison below is not measuring the turn-on transient.
  tran 100n 200u 60u
  * Compare against what the output divider alone would give, not against
  * the raw input. R3's 1k into 100k costs 1 % at DC whatever the frequency
  * does, and folding that into the budget would leave a test that passes on
  * 100 mV of arithmetic. This way the number is the amplifier's.
  let ideal = v(CABLE1) * 100/101
  let peak_out = maximum(abs(v(OUT1)))
  let peak_ideal = maximum(abs(ideal))
  let amp_err_pct = 100 * (peak_ideal - peak_out) / peak_ideal
  * Instantaneous difference, for contrast: at 20 kHz this is phase lag,
  * not amplitude, and nobody needs a utility module to be phase-linear to
  * a fraction of a degree.
  let worst = maximum(abs(abs(v(OUT1)) - abs(ideal)))
  echo "--- 20 kHz full scale, k=$kk, 100k load ---"
  print peak_out peak_ideal amp_err_pct
  echo "    instantaneous error (phase lag, not amplitude):"
  print worst
  if abs(amp_err_pct) < 0.5
    echo "PASS  amplitude holds at 20 kHz full scale, k=$kk"
  else
    echo "FAIL  amplitude drops at 20 kHz full scale, k=$kk"
  end
end
.endc
.end
