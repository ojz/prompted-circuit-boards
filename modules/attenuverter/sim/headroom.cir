* UTIL-01 channel 1: does a full-scale Eurorack signal fit at the low rail?
*
* Eurorack signals run to about +/-10 V, and at full clockwise this module
* has a gain of +1 (at full anticlockwise, -1), so the op-amp output has to
* reach +/-10 V to pass one through unharmed. The envelope in ERROR-BUDGET.md
* puts the rails at +/-12 V -5 %, so this deck runs at +/-11.4 V, which a
* series Schottky takes another 0.2 V off. The OPA2197 stops 125 mV short of
* its rails at a 10k load (datasheet maximum), and its 375 ohm open-loop
* output resistance costs a little more into the feedback network, so the
* arithmetic says about +/-10.9 V: the margin is real but worth measuring.
*
* Two nodes are checked. OA1, the op-amp output, is where the +/-10 V must
* appear. OUT1, behind the 1k protection resistor, reads 1 % lower into the
* 100k load; that divider is documented in the budget as a property of every
* Eurorack output and is not charged against the module.
*
* What this deck does NOT establish. The model clamps its output at the rail
* limit, which is a clamp and not an output stage: it says where clipping
* starts, and nothing at all about what the real part does when overdriven.
* The OPA2197's inputs are rail-to-rail and the model has no common-mode
* limit, which for this part agrees with the datasheet; for the TL072 it
* did not, and that was one of the reasons it was replaced.

.include modules/_models/devices.lib
.include modules/attenuverter/sim/attenuverter.cir

Vpos P12_RAW 0 DC 11.4
Vneg N12_RAW 0 DC -11.4
.param rp1=1m
Vsig CABLE1 0 DC 0
Rp1  CABLE1 IN1 {rp1}
Rload OUT1 0 100k

.control
alterparam norm_J1 = 1G

foreach kk 1 0
  alterparam k_RV1 = $kk
  reset
  * Full scale, both polarities: the op-amp output should still be following.
  dc Vsig -10 10 20
  let e_neg = abs(v(OA1)[0] - (2 * $kk - 1) * (-10))
  let e_pos = abs(v(OA1)[1] - (2 * $kk - 1) * 10)
  if (e_neg < 0.010) & (e_pos < 0.010)
    echo "PASS  +/-10 V reaches the op-amp output at k=$kk with 11.4 V rails"
  else
    echo "FAIL  +/-10 V does not reach the op-amp output at k=$kk"
    print e_neg e_pos
  end
  * Behind the 1k into 100k: 0.99 % down, and no more.
  let o_pos = abs(v(OUT1)[1])
  let loss_pct = 100 * (10 - o_pos) / 10
  if (loss_pct > 0.9) & (loss_pct < 1.1)
    echo "PASS  the output divider costs the documented 1 % at k=$kk"
  else
    echo "FAIL  the output divider does not read as documented at k=$kk"
    print o_pos loss_pct
  end
end

* Where does it actually stop following? Sweep past the rails and find the
* largest output either way, at unity gain.
alterparam k_RV1 = 1
reset
dc Vsig -15 15 0.1
let top = maximum(v(OA1))
let bot = minimum(v(OA1))
echo "--- clipping at +/-11.4 V rails ---"
print top bot
if (top > 10.5) & (bot < -10.5)
  echo "PASS  clipping starts more than 0.5 V outside the +/-10 V signal range"
else
  echo "FAIL  clipping starts too close to the +/-10 V signal range"
end
.endc
.end
