* UTIL-01: do the two channels stay out of each other's way?
*
* They share two things: the supply rails and the offset reference that is
* normalled to both input jacks. The first version of this module derived
* the reference from the rail with a divider that both channels loaded, and
* patching a cable into channel 1 lifted its 50k off the divider and moved
* channel 2's idle output by 41.8 mV, half a semitone. The REF5050 that
* replaced it is specified at 30 ppm/mA of load regulation, and behind the
* input buffers each channel loads it with about 5 uA, so the arithmetic
* says 0.75 uV. This deck measures it on the generated circuit.
*
* Limit, from ERROR-BUDGET.md's acceptance table: either channel's output
* moves by no more than 0.1 mV when the other is patched or turned. Channel
* 2's pot is fully clockwise so any shift passes through at full gain.
*
* What the rail path can and cannot show here: the op-amp model draws its
* quiescent current from the rails but not its load current, so a channel
* driving a heavy load does not sag the rail in this model. The REF5050's
* line regulation is modelled, so if the rail did move the reference's
* response would be counted; the rail movement itself is not predicted.

.include modules/_models/devices.lib
.include modules/attenuverter/sim/attenuverter.cir

Vpos P12_RAW 0 DC 12
Vneg N12_RAW 0 DC -12
* Channel 1's patch cable. A plug does two things at once and the deck has
* to do both: it opens the normalling switch AND connects a source. Wiring
* the source straight to the tip instead would drive the shared reference
* through the closed switch, which is a short that no unpatched jack has.
.param rp1=1G
Vsig CABLE1 0 DC 5
Rp1  CABLE1 IN1 {rp1}

.control
* Channel 2 idle and passing its offset through at full gain.
alterparam k_RV2 = 1
alterparam k_RV1 = 1

* Nothing patched anywhere: switch closed, no cable.
alterparam norm_J1 = 1m
alterparam rp1 = 1G
reset
op
* `reset` starts a new plot, so vectors do not survive it. Copy the numbers
* into shell variables, which do.
let t1 = v(OFFSET)
let t2 = v(OUT2)
set idle_ref = $&t1
set idle_out2 = $&t2
echo "--- shared offset reference ---"
echo "idle:  reference $idle_ref V, channel 2 out $idle_out2 V"

* A cable goes into channel 1: switch opens, cable connects. Channel 2 has
* not been touched.
alterparam norm_J1 = 1G
alterparam rp1 = 1m
reset
op
let busy_ref = v(OFFSET)
let busy_out2 = v(OUT2)
let ref_shift = busy_ref - $idle_ref
let out2_shift = busy_out2 - $idle_out2
print busy_ref busy_out2 ref_shift out2_shift
if abs(out2_shift) < 0.0001
  echo "PASS  channel 2 moves less than 0.1 mV when channel 1 is patched"
else
  echo "FAIL  channel 2 moves when channel 1 is patched"
end

* Channel 1's knob is turned end to end while patched.
alterparam k_RV1 = 0
reset
op
let turned_out2 = v(OUT2)
let turn_shift = turned_out2 - $idle_out2
print turn_shift
if abs(turn_shift) < 0.0001
  echo "PASS  channel 2 moves less than 0.1 mV when channel 1's knob is turned"
else
  echo "FAIL  channel 2 moves when channel 1's knob is turned"
end

* Channel 1 is driven to -10 V at full inversion, so its output sits at
* +10 V: the largest signal the module handles.
alter Vsig = -10
reset
op
let driven_out2 = v(OUT2)
let drive_shift = driven_out2 - $idle_out2
print drive_shift
if abs(drive_shift) < 0.0001
  echo "PASS  channel 2 moves less than 0.1 mV when channel 1 swings full scale (quiescent-current model, see header)"
else
  echo "FAIL  channel 2 moves when channel 1 swings full scale"
end
.endc
.end
