* UTIL-01 channel 1: what does a load do to the output, and a source to the input?
*
* Output side. There is a 1k resistor in series with the output jack (R3),
* there to protect the op-amp from a patch cable shorted to ground. It also
* forms a divider with whatever the module is plugged into. Eurorack inputs
* are usually 100k; this module's own input is now 1M, so 50k is kept as a
* historical worst case rather than a chaining case. Budget: under 2.5 %
* loss into 50k, under 1.1 % into 100k.
*
* Input side. The first version presented 50k to the cable (pot in parallel
* with R_a), so a source with the usual 1k output resistor lost 2 %, twice
* what it loses into every other module. The buffer stage exists to remove
* that term: the module now presents R9 = 1M, and ERROR-BUDGET.md allows
* 0.15 % of source loading (0.10 % predicted). Measured here as the change
* in output when the source impedance goes from 0 to 1k.

.include modules/_models/devices.lib
.include modules/attenuverter/sim/attenuverter.cir

Vpos P12_RAW 0 DC 12
Vneg N12_RAW 0 DC -12
.param rp1=1m
Vsig CABLE1 0 DC 5
Rp1  CABLE1 IN1 {rp1}
* The thing being driven, swapped by the control section.
.param rload=1T
Rload OUT1 0 {rload}

.control
alterparam norm_J1 = 1G
alterparam k_RV1 = 1

* Unloaded reference.
alterparam rload = 1T
reset
op
let t = v(OUT1)
set open_v = $&t
echo "--- output loading, unity gain, 5 V in, 0 ohm source ---"
echo "unloaded: $open_v V"

foreach rl 100k 50k 10k 1k
  alterparam rload = $rl
  reset
  op
  let loaded = v(OUT1)
  let loss_pct = 100 * ($open_v - loaded) / $open_v
  echo "load $rl:"
  print loaded loss_pct
end

alterparam rload = 100k
reset
op
let l100 = v(OUT1)
let err100 = 100 * abs($open_v - l100) / $open_v
if err100 < 1.1
  echo "PASS  under 1.1 % loss into a 100k load"
else
  echo "FAIL  too much loss into a 100k load"
  print err100
end

alterparam rload = 50k
reset
op
let l50 = v(OUT1)
let err50 = 100 * abs($open_v - l50) / $open_v
if err50 < 2.5
  echo "PASS  under 2.5 % loss into a 50k load"
else
  echo "FAIL  too much loss into a 50k load"
  print err50
end

echo "--- source loading: 1k in the cable, output open ---"
alterparam rload = 1T
alterparam rp1 = 1k
reset
op
let src_v = v(OUT1)
let src_loss_pct = 100 * ($open_v - src_v) / $open_v
print src_v src_loss_pct
if src_loss_pct < 0.15
  echo "PASS  a 1k source loses under 0.15 % into the buffered input"
else
  echo "FAIL  a 1k source loses too much into the input"
end
.endc
.end
